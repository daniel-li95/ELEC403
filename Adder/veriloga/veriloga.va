// VerilogA for ELEC403, Adder, veriloga

`include "constants.vams"
`include "disciplines.vams"

module Adder(A, B, C, OUT);

input A, B, C;
output OUT;

electrical A, B, C, OUT;

parameter real Delay = 0 from [0:inf);  // set Delay for output
parameter real Rise = 10p from [0:inf);  // set rise time for output
parameter real Fall = 10p from [0:inf);  // set fall time for outputs

real OUTBUFF;

analog begin

OUTBUFF = V(A) + V(B) + V(C);

    V(OUT) <+ transition( OUTBUFF, Delay, Rise, Fall);
end

endmodule
