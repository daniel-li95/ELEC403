// VerilogA for ELEC403, Scaler, veriloga

`include "constants.vams"
`include "disciplines.vams"

module Multiplier(IN, GAIN, OUT);

input IN;
input GAIN;
output OUT;

electrical IN, GAIN, OUT;

parameter real Delay = 0 from [0:inf);  // set Delay for output
parameter real Rise = 10p from [0:inf);  // set rise time for output
parameter real Fall = 10p from [0:inf);  // set fall time for outputs

real OUTBUFF, GAINBUFF;

analog begin

OUTBUFF = V(IN)*V(GAIN);

    V(OUT) <+ transition( OUTBUFF, Delay, Rise, Fall);

end
endmodule
