// VerilogA for ELEC403, Comparator, veriloga

`include "constants.vams"
`include "disciplines.vams"

module Comparator(A, B, OUT);

input A, B;
output OUT;

electrical A, B, OUT;

parameter real Vth = 0.5 from [0:inf); // set threshod for input and clock
parameter real Voh = 1 from [0:inf);  // set threshod for input and clock
parameter real Vol = 0 from [0:inf);  // set threshod for input and clock
parameter real Delay = 10p from [0:inf);  // set Delay for output
parameter real Rise = 10p from [0:inf);  // set rise time for output
parameter real Fall = 10p from [0:inf);  // set fall time for outputs

real OUTBUFF;

analog begin

    if (V(A) > V(B))
      OUTBUFF = Voh;
    else
      OUTBUFF = Vol;

    // create an analog version of logical output
    V(OUT) <+ transition( OUTBUFF, Delay, Rise, Fall);
end

endmodule
