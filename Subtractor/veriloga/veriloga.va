// VerilogA for ELEC403, Subtractor, veriloga

`include "constants.vams"
`include "disciplines.vams"

module Subtractor(A, B, OUT);

input A, B;
output OUT;

parameter real Delay = 10p from [0:inf);  // set Delay for output
parameter real Rise = 10p from [0:inf);  // set rise time for output
parameter real Fall = 10p from [0:inf);  // set fall time for outputs

electrical A, B, OUT;

real OUTBUFF;

analog begin

OUTBUFF = V(A) - V(B);

V(OUT) <+ transition( OUTBUFF, Delay, Rise, Fall);

end
endmodule
