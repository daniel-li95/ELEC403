// VerilogA for ELEC403, MUX, veriloga

`include "constants.vams"
`include "disciplines.vams"

module MUX(A, B, SE, OUT);

input A, B;
input SE;

output OUT;

electrical A, B, SE, OUT;

parameter real Vth = 0.6 from [0:inf); // set threshod for input and clock

parameter real Delay = 10p from [0:inf);  // set Delay for output
parameter real Rise = 10p from [0:inf);  // set rise time for output
parameter real Fall = 10p from [0:inf);  // set fall time for output

real OUTBUFF;

analog begin

if((V(SE) >  Vth))
OUTBUFF = V(B);
else
OUTBUFF = V(A);

V(OUT) <+ transition(OUTBUFF, Delay, Rise, Fall);

end

endmodule
